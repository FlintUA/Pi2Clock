* Raspberry Pi Pico 2 W Clock & Audio System
* Generated by ProtoFlow circuit diagram maker
* Pico 2 W with I2C LCD, DS1302 RTC, DFPlayer Mini, MicroSD, 2 Encoders & 5 Buttons
* Draft netlist: check every value and model before relying on the results.
* Terminals: ILLUM_OUT = ILLUM_OUT. Drive inputs with a source to simulate.

* unsupported: U1 (ic Raspberry Pi Pico 2 W): GP0 (pin 1)=I2C0_SDA GP1 (pin 2)=I2C0_SCL GP2 (pin 4)=RTC_CLK GP4 (pin 6)=RTC_CE GP5 (pin 7)=RTC_DAT GP6 (pin 9)=ILLUM_OUT GP8 (pin 11)=SD_MISO GP9 (pin 12)=SD_CS GP10 (pin 14)=SD_SCK GP11 (pin 15)=SD_MOSI GP12 (pin 16)=ENC1_DT GP13 (pin 17)=ENC1_CLK GP14 (pin 19)=ENC2_DT GP15 (pin 20)=ENC2_CLK GP16 (pin 21)=DF_RX GP17 (pin 22)=DF_TX GP18 (pin 24)=DF_BUSY GP19 (pin 25)=ENC1_SW GP20 (pin 26)=ENC2_SW GP21 (pin 27)=BTN_ALARM GP22 (pin 29)=BTN_MODE GP26 (pin 31)=BTN_MINUS GP27 (pin 32)=BTN_PLUS GP28 (pin 34)=BTN_TIMER 3V3_OUT (pin 36)=0 VBUS (pin 40)=P5V_VBUS GND (pin 38)=0
* unsupported: U2 (ic LCD1602 I2C Backpack): SDA=I2C0_SDA SCL=I2C0_SCL VCC=P5V_VBUS GND=0
* unsupported: U3 (ic DS1302 RTC Module): CLK=RTC_CLK DAT=RTC_DAT RST=RTC_CE VCC=0 GND=0
* unsupported: U4 (ic MicroSD SPI Module): CS=SD_CS SCK=SD_SCK MOSI=SD_MOSI MISO=SD_MISO VCC=0 GND=0
* unsupported: U5 (ic DFPlayer Mini): RX=N2 TX=DF_TX BUSY=DF_BUSY SPK1=N3 SPK2=N4 VCC=P5V_VBUS GND=0
R1 N2 DF_RX 1k
* SPK1: speaker as its nominal resistance
RSPK1 N3 N4 8
* unsupported: U6 (ic Timer Rotary Encoder): CLK=ENC1_CLK DT=ENC1_DT SW=ENC1_SW +=0 GND=0
* unsupported: U7 (ic Volume Rotary Encoder): CLK=ENC2_CLK DT=ENC2_DT SW=ENC2_SW +=0 GND=0
* SW1: open push button between BTN_ALARM and 0 (not simulated)
* SW2: open push button between BTN_MODE and 0 (not simulated)
* SW3: open push button between BTN_MINUS and 0 (not simulated)
* SW4: open push button between BTN_PLUS and 0 (not simulated)
* SW5: open push button between BTN_TIMER and 0 (not simulated)

* Supplies from the power symbols
VSUPPLY_P5V_VBUS P5V_VBUS 0 DC 5

.op
.end
